* Proton netlist
C1 out 0 100n
R1 in out 1k
* gen1
* function generator gen1
Vgen1 in 0 SIN(0 1 1k)
