* Proton netlist
C1 out 0 1u
R1 in out 1k
* gen1
* function generator gen1
Vgen1 in 0 PULSE(0 2 0 10u 10u 4.99m 10m)
