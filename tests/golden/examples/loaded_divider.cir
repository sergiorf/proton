* Proton netlist
R1 in out 10k
R2 out 0 10k
R3 out 0 10k
V1 in 0 DC 5
